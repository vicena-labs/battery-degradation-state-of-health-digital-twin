Battery 1RC Thevenin pulse response, illustrative parameters
V_OCV ocv 0 3.70
I_LOAD out 0 PULSE(0 3.0 1m 1u 1u 90.0 180.0)
R0 ocv n1 0.032
R1 n1 out 0.018
C1 n1 out 2400.0
.tran 0.3 180.0
.print tran time v(out) v(n1)
.measure tran v_terminal_mid FIND v(out) AT=60.0
.measure tran v_terminal_min MIN v(out)
.end
